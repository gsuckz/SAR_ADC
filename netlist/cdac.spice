** sch_path: /foss/designs/SAR_ADC/xschem/designs/cdac.sch
**.subckt cdac xd in d[9] d[7] d[0] d[11] d[3] d[4] d[2] d[1] d[8] d[6] d[5] d[10] gnd vdd
*.ipin d[0]
*.ipin d[1]
*.ipin d[2]
*.ipin d[3]
*.ipin d[4]
*.ipin d[5]
*.ipin d[6]
*.ipin d[7]
*.ipin d[8]
*.ipin d[9]
*.ipin d[10]
*.ipin d[11]
*.iopin vdd
*.iopin gnd
*.iopin in
*.iopin xd
x1 in vdd gnd d[0] cdac_line CW={cu} CL={cu} n=1
x2 in vdd gnd d[1] cdac_line CW={2*cu} CL={2*cu} n=1
x3 in vdd gnd d[2] cdac_line CW={4*cu} CL={4*cu} n=2
x4 in vdd gnd d[3] cdac_line CW={8*cu} CL={8*cu} n=4
x5 in vdd gnd d[4] cdac_line CW={16*cu} CL={16*cu} n=8
x6 in vdd gnd d[5] cdac_line CW={32*cu} CL={32*cu} n=16
XCA xd in cap_mim_2f0fF c_width={sqrt((64*cu)/(2*63))*1u} c_length={sqrt((64*cu)/(2*63))*1u} m=1
x7 xd vdd gnd d[6] cdac_line CW={sqrt(1)*cu} CL={sqrt(1)*cu} n=1
x8 xd vdd gnd d[7] cdac_line CW={2*cu} CL={2*cu} n=2
x9 xd vdd gnd d[8] cdac_line CW={4*cu} CL={4*cu} n=4
x10 xd vdd gnd d[9] cdac_line CW={8*cu} CL={8*cu} n=8
x11 xd vdd gnd d[10] cdac_line CW={16*cu} CL={16*cu} n=16
x12 xd vdd gnd d[11] cdac_line CW={32*cu} CL={32*cu} n=32
XC1 in gnd cap_mim_2f0fF c_width={sqrt(cu/2)*1u} c_length={sqrt(cu/2)*1u} m=1
**.ends

* expanding   symbol:  cdac_line.sym # of pins=4
** sym_path: /foss/designs/SAR_ADC/xschem/designs/cdac_line.sym
** sch_path: /foss/designs/SAR_ADC/xschem/designs/cdac_line.sch
.subckt cdac_line vout vdd gnd vin  CW=1e-6 CL=1e-6 n=1
*.ipin vdd
*.ipin gnd
*.ipin vin
*.opin vout
XC1 vout net1 cap_mim_2f0fF c_width={sqrt(CW/2)*1u} c_length={sqrt(CL/2)*1u} m=1
x3 vdd gnd net1 net2 inv cl=0.28u wp=0.44u wn=0.22u wx={n*1u} mx=1
x1 vdd gnd net2 vin inv cl=0.28u wp=0.44u wn=0.22u wx=1u mx=n
.ends

* expanding   symbol:  inv.sym # of pins=4
** sym_path: /foss/designs/SAR_ADC/xschem/designs/inv.sym
** sch_path: /foss/designs/SAR_ADC/xschem/designs/inv.sch
.subckt inv vdd gnd vout vin  cl=0.28u wp=0.44u wn=0.22u wx=0.22u mx=1
*.ipin gnd
*.ipin vdd
*.ipin vin
*.opin vout
XM1 gnd vin vout gnd nfet_03v3 L=0.28u W=Wx nf=1 ad='int((nf+1)/2) * W/nf * 0.18u' as='int((nf+2)/2) * W/nf * 0.18u' pd='2*int((nf+1)/2) * (W/nf + 0.18u)'
+ ps='2*int((nf+2)/2) * (W/nf + 0.18u)' nrd='0.18u / W' nrs='0.18u / W' sa=0 sb=0 sd=0 m=mx
XM2 vdd vin vout vdd pfet_03v3 L=0.28u W={Wx*1.4} nf=1 ad='int((nf+1)/2) * W/nf * 0.18u' as='int((nf+2)/2) * W/nf * 0.18u' pd='2*int((nf+1)/2) * (W/nf + 0.18u)'
+ ps='2*int((nf+2)/2) * (W/nf + 0.18u)' nrd='0.18u / W' nrs='0.18u / W' sa=0 sb=0 sd=0 m=mx
.ends

.end
